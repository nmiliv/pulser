.title aaaaaa
.model UPSC600 D(Is=2p Rs=.33 N=1.5 Cjo=50p M=.3 bv=600)
V1 N003A 0 24
RV1 N003A N003 1m
CV1 N003A 0 1n
V2 N004A 0 PULSE(0 5 1u 10u 10u 90u 1m)
RV2 N004A N004 1m
CV2 N004A 0 1n
R1 N005 N004 10
R2 N005 0 1Meg
R3 N003 N002 100
Q1 N001 N005 0 0 BD135_mod
CQ N001 0 60n
D1 N001 N002 UPSC600
CD N001 N002 1n
L1 N001 lrser 175m
R4 N002 lrser 1m
.model BD135_mod
+ NPN(
+ Is=40f
+ Xti=3
+ Eg=1.11
+ Vaf=115.7
+ Bf=180.2
+ Ise=40f
+ Ne=1.363
+ Ikf=4.927
+ Nk=1.247
+ Xtb=1.5
+ Br=10
+ Isc=85f
+ Nc=2
+ Ikr=0
+ Rc=0.15
+ Re=0.1
+ Cjc=19.23p
+ Mjc=.3439
+ Vjc=.5635
+ Fc=.5
+ Cje=60.49p
+ Mje=.3589
+ Vje=.7585
+ Tr=116n
+ Tf=550p
+ Itf=1
+ Xtf=0
+ Vtf=10
+ QCO=1E-10
+ GAMMA=1E-8
+ RCO=5)
.options reltol=0.01
.tran 10n 1m
.end
